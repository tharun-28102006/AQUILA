AQUILA - spectral sidelobe comparison, 300 kHz pulse
.param MODE=1 WAVE=2 ZOH=1 WIN=0
.param FCAR=300k FSTART=200k FEND=400k TPULSE=2m SCALE=1
.include aquila_hardware_parameters.inc
.include aquila_models_and_power.inc
.include aquila_dac_stimulus.inc
.include aquila_signal_chain.inc
.step param WIN list 0 1
.tran 0 {TSTOP} 0 {TMAX}
.include aquila_transient_measurements.inc
.end
