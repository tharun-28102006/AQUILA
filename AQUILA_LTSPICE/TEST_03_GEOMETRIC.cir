AQUILA - sampled Blackman exponential frequency sweep
.param MODE=3 WAVE=2 ZOH=1 WIN=1
.param FCAR=300k FSTART=200k FEND=400k TPULSE=2m SCALE=1
.include aquila_hardware_parameters.inc
.include aquila_models_and_power.inc
.include aquila_dac_stimulus.inc
.include aquila_signal_chain.inc

.tran 0 {TSTOP} 0 {TMAX}
.include aquila_transient_measurements.inc
.end
