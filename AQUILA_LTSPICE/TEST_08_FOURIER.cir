AQUILA - steady 300 kHz Fourier check; stop before the burst ends
.param MODE=1 WAVE=2 ZOH=1 WIN=0
.param FCAR=300k FSTART=200k FEND=400k TPULSE=2m SCALE=1
.include aquila_hardware_parameters.inc
.include aquila_models_and_power.inc
.include aquila_dac_stimulus.inc
.include aquila_signal_chain.inc
.meas TRAN FOURIER_RMS RMS V(V_LOAD) FROM {TSTART+1m} TO {TSTART+TPULSE-20u}
.tran 0 {TSTART+TPULSE-20u} 0 {TMAX}
.four {FCAR} 15 60 V(V_LOAD)
.end
